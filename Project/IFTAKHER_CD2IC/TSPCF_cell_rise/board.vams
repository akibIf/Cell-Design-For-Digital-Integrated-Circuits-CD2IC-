// This module is a kind of test board fot the device under test (DUT)
// This module is written in "Verilog-AMS" language
//
// it's function is :
// - to generate electrical signals for the DUT
// - to extract measurements
// - to send measurements to the digital testbench
//
// 1/ The device under test is an TSPCFF
//
// 2/ The expected measurement is the "propagation time, for a rising output"

`timescale 1ns/100fs

// Mandatory for  AMS
`include "constants.vams"
`include "disciplines.vams"

// The board
module board(
                        // From the testbench
                        clk_logic,
                        din_logic          , // A logic signal generated by the testbench, and used to generate an input to the TSPCFF
                        load_capacitor_val , // The expected value of a load capacitor loading the output of the TSPCFF
                        din_tt_val             , // The expected value of the transition time of the input
                        clk_tt_val             ,
                        din_delay_val          , // An arbitrary incremental delay added to the input transition
                        clk_delay_val      ,
                        // To the testbench
                        propagation,     // The measured  propagation time for a rising output
                        dout_electrical     // The output of the  dut
                        ) ;

// IO defs
input   clk_logic          ;
input   din_logic          ; // A logic signal generated by the testbench, and used to generate an input to the TSPCFF
input   load_capacitor_val ; // The expected value of a load capacitor loading the output of the TSPCFF
input   din_tt_val         ; // The expected value of the transition time of the input
input   clk_tt_val         ;
input   din_delay_val          ; // An arbitrary incremental delay added to the input transition
input   clk_delay_val      ;
output  propagation    ; // The measured propagation time for a rising output
output  dout_electrical    ; // Output signal of the TSPCFF (used only to check the result of the simulation

// Nature of the signal
wire clk_logic ;
wire  din_logic          ; // A logic signal generated by the testbench, and used to generate an input to the TSPCFF
wreal load_capacitor_val ; // The expected value of a load capacitor loading the output of the TSPCFF
wreal din_tt_val         ; // The expected value of the transition time of the input
wreal clk_tt_val         ;
wreal din_delay_val          ; // An arbitrary incremental delay added to the input transition
wreal clk_delay_val      ;
wreal propagation    ; // The measured propagation time for a rising output
electrical dout_electrical    ; // Output signal of the TSPCFF

// Static parameters for the characterization
parameter real  power_voltage = 1.1 ; // volts
parameter real  slew_lower_threshold_pct 	= 0.3 ; // Fraction of the full swing
parameter real  slew_upper_threshold_pct 	= 0.7 ; // Fraction of the full swing
localparam real  input_threshold_pct      	= 0.5 ; // Fraction of the full swing
localparam real  output_threshold_pct      	= 0.5 ; // Fraction of the full swing

///////////////////////////////////////////////////////////////
// The analog world...
///////////////////////////////////////////////////////////////

// Internal Signals
electrical din_electrical     ; // Input signal of the TSPCFF
electrical clk_electrical     ;// clock signal of the TSPCFF

// nodes for power supplies
electrical vss          ; // The ground reference
ground vss              ; // This is a global ground associated to the node "0" of the electrical simulator
electrical vdd          ; // Power supply of the device under test
electrical tmp ;

// Branches for power supplies, passive dipoles...
branch (vdd,vss) power_dut                ; //  The power supply branch is named power_dut
branch (dout_electrical,vss) load_capacitor   ; //  The passive branch for the load capacitor
branch (tmp,vss) tmp_val;

// Equations for the branches
analog
begin
 // The power_dut branch is an ideal voltage source
 V(power_dut) <+ power_voltage ;
 // The load_capacitor branch is an ideal capacitor
 // Smooth the capacitor update in order to limit simulator convergence problems
 I(load_capacitor) <+ ddt(V(load_capacitor))*transition(load_capacitor_val,0,1p,1p);

 //I(load_capacitor) <+ ddt(V(load_capacitor))*load_capacitor_val ;
end

// Here we generate the input transitions using the variables transmitted by the testbench
cmos_transition cmos_tr_din(.din(din_logic),.dout(din_electrical),.tt_val(din_tt_val),.delay_val(din_delay_val)) ;
cmos_transition cmos_tr_clk(.din(clk_logic),.dout(clk_electrical),.tt_val(clk_tt_val),.delay_val(clk_delay_val)) ;
// The device under test is simply connected to the signals.
// All gates from the gsclib045 may be used in this netlist.
TSPCFF dut (.VDD(vdd),.VSS(vss),.D(din_electrical),.CK(clk_electrical), .Y(dout_electrical)) ;

///////////////////////////////////////////////////////////////
// The measurements
///////////////////////////////////////////////////////////////

///////////////////////////////////////////////////////////////
// Propagation time for a rising output
///////////////////////////////////////////////////////////////
real input_transition_time  ;
real output_transition_time   ;

// We detect the start of a rise propagation
always @(cross(V(clk_electrical)-power_voltage*input_threshold_pct, 1,1e-15,1e-4 ))
   input_transition_time  = $abstime ;

// We detect the end of a rise propagation
always @(cross(V(dout_electrical)-power_voltage*output_threshold_pct, 1,1e-15,1e-4 ))
   output_transition_time  = $abstime ;

assign propagation = output_transition_time  - input_transition_time  ;

endmodule
